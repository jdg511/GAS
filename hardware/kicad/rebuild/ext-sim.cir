.title KiCad schematic
.include "C:/Users/Jason/GAS-build/repo/hardware/kicad/sim/ext-tank-routing-sim/gas-models.lib"
.tran 10u 30m
.options savecurrents
R232 N_SECBUF_R N_SECFB_R 0
XU201 N_TMIX_L N_SUM_L_M AGND +15VA AGND N_SUM_R_M N_TMIX_R N_SECBUF_L N_SECFB_L SEC_DRV_L -15VA SEC_DRV_R N_SECFB_R N_SECBUF_R OPA1679X4
R202 PRI_RET_L N_SUM_L_M 20k
RP2 EXTMIX_L_WIPER AGND 10k
RL5 PRI_SEND_L AGND 10k
R229 N_TMIX_R N_SUM_R_M 20k
R223 EXTMIX_R_WIPER N_SUM_R_M 20k
R225 N_TMIX_R TANK_MIX_R 100
XU202 SEND_MIX_L N_SND_L_M AGND -15VA AGND N_SND_R_M SEND_MIX_R +15VA OPA1656X2
C291 +15VA AGND 100n
C294 -15VA AGND 22u
C295 +5VAUX AGND 100n
V1 +15VA GND DC 15
V2 GND -15VA DC 15
V3 AGND GND DC 0
C296 +15VA AGND 100n
C292 -15VA AGND 100n
C297 -15VA AGND 100n
C293 +15VA AGND 22u
V6 FB_RET_L AGND DC 0 SIN( 0 0.2 1.5k )
RS3 SEC_RET_L EXTMIX_L_HI 10m
RP1 EXTMIX_L_HI EXTMIX_L_WIPER 10k
V7 FB_RET_R AGND DC 0 SIN( 0 0.2 1.5k )
V4 PRI_RET_L AGND DC 0 SIN( 0 0.3 600 )
V5 PRI_RET_R AGND DC 0 SIN( 0 0.3 600 )
RL3 SEC_SEND_L AGND 10k
RL4 SEC_SEND_R AGND 10k
RS1 PRI_RET_L SEC_SEL_L 10m
RS2 SEC_SEL_L SEC_DRV_L 10m
V10 WET_SEND_R AGND DC 0 SIN( 0 0.4 1k )
RL2 TANK_MIX_R AGND 10k
RP4 EXTMIX_R_WIPER AGND 10k
RL1 TANK_MIX_L AGND 10k
V9 WET_SEND_L AGND DC 0 SIN( 0 0.4 1k )
V8 SEC_RET_L AGND DC 0 SIN( 0 0.25 2k )
RP3 EXTMIX_R_HI EXTMIX_R_WIPER 10k
R226 N_SECBUF_R SEC_SEND_R 100
R203 EXTMIX_L_WIPER N_SUM_L_M 20k
R209 N_TMIX_L N_SUM_L_M 20k
R222 PRI_RET_R N_SUM_R_M 20k
R205 N_TMIX_L TANK_MIX_L 100
R228 SEND_MIX_R N_SND_R_M 20k
R207 WET_SEND_L N_SND_L_M 20k
R204 FB_RET_L N_SND_L_M 20k
R211 SEC_DRV_L AGND 100k
R208 SEND_MIX_L N_SND_L_M 20k
R201 SEND_MIX_L PRI_SEND_L 100
R221 SEND_MIX_R PRI_SEND_R 100
R227 WET_SEND_R N_SND_R_M 20k
R224 FB_RET_R N_SND_R_M 20k
R231 SEC_DRV_R AGND 100k
R212 N_SECBUF_L N_SECFB_L 0
R206 N_SECBUF_L SEC_SEND_L 100
.end
