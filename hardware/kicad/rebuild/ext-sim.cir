.title KiCad schematic
.include "C:/Users/Jason/GAS-build/repo/hardware/kicad/sim/ext-tank-routing-sim/gas-models.lib"
.tran 10u 30m
.options savecurrents
RP2 EXTMIX_L_WIPER AGND 10k
RP3 EXTMIX_R_HI EXTMIX_R_WIPER 10k
RL5 PRI_SEND_L AGND 10k
C293 +15VA AGND 22u
R225 N_TMIX_R TANK_MIX_R 100
C294 -15VA AGND 22u
C295 +5VAUX AGND 100n
R229 N_TMIX_R N_SUM_R_M 20k
R204 FB_RET_L N_SUM_L_M 20k
XU201 N_TMIX_L N_SUM_L_M AGND +15VA AGND N_SUM_R_M N_TMIX_R N_SECBUF_L N_SECFB_L SEC_DRV_L -15VA SEC_DRV_R N_SECFB_R N_SECBUF_R OPA1679X4
V3 AGND GND DC 0
V2 GND -15VA DC 15
V9 WET_SEND_L AGND DC 0 SIN( 0 0.4 1k )
C292 -15VA AGND 100n
C291 +15VA AGND 100n
V8 SEC_RET_L AGND DC 0 SIN( 0 0.25 2k )
V1 +15VA GND DC 15
R205 N_TMIX_L TANK_MIX_L 100
R209 N_TMIX_L N_SUM_L_M 20k
R222 PRI_RET_R N_SUM_R_M 20k
R203 EXTMIX_L_WIPER N_SUM_L_M 20k
R202 PRI_RET_L N_SUM_L_M 20k
R223 EXTMIX_R_WIPER N_SUM_R_M 20k
R224 FB_RET_R N_SUM_R_M 20k
RS2 SEC_SEL_L SEC_DRV_L 10m
V4 PRI_RET_L AGND DC 0 SIN( 0 0.3 600 )
V5 PRI_RET_R AGND DC 0 SIN( 0 0.3 600 )
RS3 SEC_RET_L EXTMIX_L_HI 10m
RP1 EXTMIX_L_HI EXTMIX_L_WIPER 10k
RL2 TANK_MIX_R AGND 10k
RL3 SEC_SEND_L AGND 10k
RL4 SEC_SEND_R AGND 10k
V6 FB_RET_L AGND DC 0 SIN( 0 0.2 1.5k )
V7 FB_RET_R AGND DC 0 SIN( 0 0.2 1.5k )
RS1 PRI_RET_L SEC_SEL_L 10m
V10 WET_SEND_R AGND DC 0 SIN( 0 0.4 1k )
RP4 EXTMIX_R_WIPER AGND 10k
RL1 TANK_MIX_L AGND 10k
R201 WET_SEND_L PRI_SEND_L 100
R221 WET_SEND_R PRI_SEND_R 100
R206 N_SECBUF_L SEC_SEND_L 100
R231 SEC_DRV_R AGND 100k
R232 N_SECBUF_R N_SECFB_R 0
R211 SEC_DRV_L AGND 100k
R212 N_SECBUF_L N_SECFB_L 0
R226 N_SECBUF_R SEC_SEND_R 100
.end
