.title KiCad schematic
.include "C:/Users/Jason/GAS-build/repo/hardware/kicad/sim/crossfade-feedback-wet-sim/gas-models.lib"
.tran 10u 30m
.options savecurrents
RS2 FILTCLIP_OUT_R FB_SEL_R 10m
RP8 FB_R_WIPER AGND 10k
RS1 FILTCLIP_OUT_L FB_SEL_L 10m
RL6 FB_RET_R AGND 10k
RL5 FB_RET_L AGND 10k
C391 +15VA AGND 100n
XU301 XFADE_SUM_L N_XF_L_M AGND +15VA AGND N_XF_R_M XFADE_SUM_R FB_INV_L N_FB_L_M AGND -15VA AGND N_FB_R_M FB_INV_R OPA1679X4
C392 -15VA AGND 100n
C393 +15VA AGND 22u
C394 -15VA AGND 22u
V7 FILTCLIP_OUT_R AGND DC 0 SIN( 0 0.5 1.7k )
V4 TANK_MIX_L AGND DC 0 SIN( 0 0.5 1k 0 0 0 ) AC 1
V1 +15VA GND DC 15
V2 GND -15VA DC 15
RP3 TANK_MIX_R XFD_R_WIPER 10k
RP1 TANK_MIX_L XFD_L_WIPER 10k
RP2 XFD_L_WIPER TANK_MIX_R 10k
V3 AGND GND DC 0
RP5 FILTCLIP_OUT_L FB_L_WIPER 10k
RL2 XFADE_OUT_R AGND 10k
RP4 XFD_R_WIPER TANK_MIX_L 10k
RL1 XFADE_OUT_L AGND 10k
RP6 FB_L_WIPER AGND 10k
RP7 FILTCLIP_OUT_R FB_R_WIPER 10k
RL3 WET_SUM_L AGND 10k
RL4 WET_SUM_R AGND 10k
V5 TANK_MIX_R AGND DC 0 SIN( 0 0.5 700 )
V6 FILTCLIP_OUT_L AGND DC 0 SIN( 0 0.5 1.3k )
R341 FILTCLIP_OUT_L WET_SUM_L 100
R342 FILTCLIP_OUT_R WET_SUM_R 100
R301 XFD_L_WIPER N_XF_L_M 20k
R312 XFADE_SUM_R XFADE_OUT_R 100
R324 FB_R_WIPER N_FB_R_M 20k
R326 FB_INV_R N_FB_R_M 10k
R351 +15VA N_K301_C 240
R311 XFADE_SUM_L XFADE_OUT_L 100
R309 XFADE_SUM_L N_XF_L_M 20k
R321 FILTCLIP_OUT_L N_FB_L_M 20k
R325 FB_INV_L N_FB_L_M 10k
R323 FB_L_WIPER N_FB_L_M 20k
R322 FILTCLIP_OUT_R N_FB_R_M 20k
R302 XFD_R_WIPER N_XF_R_M 20k
R310 XFADE_SUM_R N_XF_R_M 20k
R331 FB_SEL_L FB_RET_L 100
R332 FB_SEL_R FB_RET_R 100
.end
