.title KiCad schematic
.include "C:/Users/Jason/GAS-build/repo/hardware/kicad/sim/filter-clipper-sim/gas-models.lib"
.tran 5u 20m
.options savecurrents
R401 HPF_F_L_WIPER AGND 1k
XU401 N_HPF_OUT_L N_HPF_OUT_L HPF_F_L_HI +15VA HPF_F_R_HI N_HPF_OUT_R N_HPF_OUT_R N_DRV_OUT_L N_DRV_M_L N_HPF_OUT_L -15VA N_HPF_OUT_R N_DRV_M_R N_DRV_OUT_R OPA1679X4
R405 N_DRV_OUT_L N_CLIP_L 4.7k
D401 N_SI_L DRV_HI D1N4148
C401 XFADE_OUT_L HPF_F_L_HI 47n
R404 N_DRV_M_L AGND 10k
R408 N_BUF_OUT_L FILTCLIP_OUT_L 100
XU402 N_LPF_OUT_L N_LPF_OUT_L LPF_F_L_WIPER +15VA LPF_F_R_WIPER N_LPF_OUT_R N_LPF_OUT_R N_BUF_OUT_L N_BUF_OUT_L N_LPF_OUT_L -15VA N_LPF_OUT_R N_BUF_OUT_R N_BUF_OUT_R OPA1679X4
R406 N_CLIP_L LPF_F_L_HI 1k
D409 N_GE_L DRV_HI DSCHOTTKY
D410 DRV_HI N_GE_L DSCHOTTKY
R403 N_DRV_OUT_L N_DRV_M_L 39k
R402 N_HPF_OUT_L HPF_Q_L_WIPER 47k
C403 HPF_Q_L_WIPER HPF_F_L_HI 10n
R423 N_DRV_OUT_R N_DRV_M_R 39k
C427 LPF_Q_R_WIPER LPF_F_R_WIPER 10n
D408 DRV_HI N_LED_R DLED
D407 N_LED_R DRV_HI DLED
R427 N_LPF_OUT_R LPF_Q_R_WIPER 47k
D404 DRV_HI N_SI_R D1N4148
C423 HPF_Q_R_WIPER HPF_F_R_HI 10n
C421 XFADE_OUT_R HPF_F_R_HI 47n
R421 HPF_F_R_WIPER AGND 1k
R424 N_DRV_M_R AGND 10k
R425 N_DRV_OUT_R N_CLIP_R 4.7k
R422 N_HPF_OUT_R HPF_Q_R_WIPER 47k
D403 N_SI_R DRV_HI D1N4148
R426 N_CLIP_R LPF_F_R_HI 1k
C426 LPF_F_R_WIPER AGND 10n
D411 N_GE_R DRV_HI DSCHOTTKY
D412 DRV_HI N_GE_R DSCHOTTKY
D405 N_LED_L DRV_HI DLED
D406 DRV_HI N_LED_L DLED
R407 N_LPF_OUT_L LPF_Q_L_WIPER 47k
C407 LPF_Q_L_WIPER LPF_F_L_WIPER 10n
D402 DRV_HI N_SI_L D1N4148
C406 LPF_F_L_WIPER AGND 10n
C596 -15VA AGND 22u
V3 AGND GND DC 0
V1 +15VA GND DC 15
V2 GND -15VA DC 15
RP3 LPF_F_L_HI LPF_F_L_WIPER 5k
RP4 LPF_F_R_HI LPF_F_R_WIPER 5k
RP5 DRV_HI DRV_WIPER 100
C591 +15VA AGND 100n
R428 N_BUF_OUT_R FILTCLIP_OUT_R 100
RP2 HPF_F_R_HI HPF_F_R_WIPER 50k
V4 XFADE_OUT_L AGND DC 0 SIN( 0 0.3 1k 0 0 0 ) AC 1
V5 XFADE_OUT_R AGND DC 0 SIN( 0 0.3 1k )
RP1 HPF_F_L_HI HPF_F_L_WIPER 50k
RS1 N_CLIP_L N_SI_L 10m
RL1 FILTCLIP_OUT_L AGND 10k
RL2 FILTCLIP_OUT_R AGND 10k
C592 -15VA AGND 100n
C593 +15VA AGND 100n
R432 DRV_WIPER AGND 100
C594 -15VA AGND 100n
C595 +15VA AGND 22u
.end
