.title KiCad schematic
.include "C:/Users/Jason/GAS-build/repo/hardware/kicad/sim/tank-driver-recovery-sim/gas-models.lib"
.include "C:/Users/Jason/GAS-build/repo/hardware/kicad/sim/tank-driver-recovery-sim/tanks.lib"
.tran 20u 60m

; switch to AC analysis by commenting .tran and uncommenting:
; .ac dec 50 10 100k
.options savecurrents
R152 SEC_DRV_R N_SEC_R_M 12k
R154 N_SEC_R_M AGND 10k
R156 SEC_DRV_R SEC_OUT_R 220
R171 PRI_REC_L_IN AGND 2.2Meg
XU103 PRI_RET_L N_PRI_RET_L_M N_REC_PL_IN -15VA N_REC_PR_IN N_PRI_RET_R_M PRI_RET_R +15VA OPA1656X2
R183 PRI_REC_L_IN N_REC_PL_IN 10m
XU101 PRI_DRV_L N_PRI_L_M N_PRI_L_P -15VA N_PRI_R_P N_PRI_R_M PRI_DRV_R +15VA OPA1656X2
R107 PRI_SEND_L N_PRI_L_P 10k
Q102 -15VA N_Q102_B N_Q102_E BD140_16
R103 N_Q101_E PRI_OUT_L 0.33
Q101 +15VA N_Q101_B N_Q101_E BD139_16
R106 PRI_SEND_L N_PRI_L_M 1k
R108 PRI_OUT_L N_PRI_L_M 10k
R102 PRI_DRV_L N_Q102_B 68
R101 PRI_DRV_L N_Q101_B 68
R121 PRI_DRV_R N_Q103_B 68
R122 PRI_DRV_R N_Q104_B 68
C101 N_ZOB_L AGND 47n
R104 N_Q102_E PRI_OUT_L 0.33
R105 PRI_OUT_L N_ZOB_L 10
R128 PRI_OUT_R N_PRI_R_M 10k
R123 N_Q103_E PRI_OUT_R 0.33
R126 PRI_SEND_R N_PRI_R_M 1k
R127 PRI_SEND_R N_PRI_R_P 10k
Q103 +15VA N_Q103_B N_Q103_E BD139_16
Q104 -15VA N_Q104_B N_Q104_E BD140_16
XU102 SEC_DRV_L N_SEC_L_M N_SEC_L_P -15VA N_SEC_R_P N_SEC_R_M SEC_DRV_R +15VA OPA1656X2
R157 SEC_SEND_L N_SEC_L_P 10k
R153 N_SEC_L_M AGND 10k
R151 SEC_DRV_L N_SEC_L_M 12k
R125 PRI_OUT_R N_ZOB_R 10
R158 SEC_SEND_R N_SEC_R_P 10k
R124 N_Q104_E PRI_OUT_R 0.33
R155 SEC_DRV_L SEC_OUT_L 220
C121 N_ZOB_R AGND 47n
R175 N_PRI_RET_L_M AGND 1k
R179 PRI_RET_L N_PRI_RET_L_M 33k
C171 PRI_RET_L N_PRI_RET_L_M 68p
R172 PRI_REC_R_IN AGND 2.2Meg
R173 SEC_REC_L_IN AGND 2.2Meg
XU104 SEC_RET_L N_SEC_RET_L_M N_REC_SL_IN -15VA N_REC_SR_IN N_SEC_RET_R_M SEC_RET_R +15VA OPA1656X2
R186 SEC_REC_R_IN N_REC_SR_IN 10m
R174 SEC_REC_R_IN AGND 2.2Meg
R178 N_SEC_RET_R_M AGND 1k
R182 SEC_RET_R N_SEC_RET_R_M 33k
C174 SEC_RET_R N_SEC_RET_R_M 68p
C291 +15VA AGND 100n
C292 +15VA AGND 100n
C293 +15VA AGND 100n
R184 PRI_REC_R_IN N_REC_PR_IN 10m
R185 SEC_REC_L_IN N_REC_SL_IN 10m
R177 N_SEC_RET_L_M AGND 1k
R180 PRI_RET_R N_PRI_RET_R_M 33k
R176 N_PRI_RET_R_M AGND 1k
C172 PRI_RET_R N_PRI_RET_R_M 68p
C173 SEC_RET_L N_SEC_RET_L_M 68p
R181 SEC_RET_L N_SEC_RET_L_M 33k
C296 -15VA AGND 100n
C297 -15VA AGND 100n
C294 +15VA AGND 100n
C295 -15VA AGND 100n
XTK1 PRI_OUT_L GND PRI_REC_L_IN GND TANK_4AB1C1B
XTK2 PRI_OUT_R GND PRI_REC_R_IN GND TANK_4AB1C1B
XTK3 SEC_OUT_L GND SEC_REC_L_IN GND TANK_9EB2C1B
V1 +15VA GND DC 15
V2 GND -15VA DC 15
V3 AGND GND DC 0
C299 +15VA AGND 22u
C300 -15VA AGND 22u
C298 -15VA AGND 100n
V6 SEC_SEND_L AGND DC 0 SIN( 0 0.5 1k 0 0 0 ) AC 1
V4 PRI_SEND_L AGND DC 0 SIN( 0 0.5 1k 0 0 0 ) AC 1
XTK4 SEC_OUT_R GND SEC_REC_R_IN GND TANK_9EB3C1B
V5 PRI_SEND_R AGND DC 0 SIN( 0 0.5 1k 0 0 0 ) AC 1
V7 SEC_SEND_R AGND DC 0 SIN( 0 0.5 1k 0 0 0 ) AC 1
.end
