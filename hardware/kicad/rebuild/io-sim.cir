.title KiCad schematic
.include "C:/Users/Jason/GAS-build/repo/hardware/kicad/sim/io-board-sim/gas-models.lib"
.tran 10u 30m
.options savecurrents
XU1 L_RX N_U1A_M N_U1A_P +15VA N_U1B_P N_U1B_M R_RX L_PROG L_PROG L_RX -15VA MONO_C R_PROG R_PROG OPA1679X4
R16 R_RX N_U1B_M 10k
R21 L_PROG DRY_L 100
R17 N_INR_P N_U1B_P 10k
R18 N_U1B_P AGND 10k
R1 IN_BAL_L_P N_INL_P 100
R2 IN_BAL_L_N N_INL_N 100
R3 IN_BAL_R_P N_INR_P 100
R4 IN_BAL_R_N N_INR_N 100
R14 N_U1A_P AGND 10k
R32 WD_R_WIPER N_U2B_M 20k
R36 R_BLEND N_U2B_M 20k
R22 L_PROG WET_SEND_L 100
R23 R_PROG DRY_R 100
XU2 L_BLEND N_U2A_M AGND -15VA AGND N_U2B_M R_BLEND +15VA OPA1656X2
R31 WD_L_WIPER N_U2A_M 20k
R35 L_BLEND N_U2A_M 20k
R24 R_PROG WET_SEND_R 100
R11 N_INL_N N_U1A_M 10k
R12 L_RX N_U1A_M 10k
R15 N_INR_N N_U1B_M 10k
R13 N_INL_P N_U1A_P 10k
RL1 OUT_BAL_L_P OUT_BAL_L_N 600
RP1 L_PROG WD_L_WIPER 10k
V4 IN_BAL_L_P AGND DC 0 SIN( 0 0.5 1k )
RP3 R_PROG WD_R_WIPER 10k
V5 IN_BAL_L_N AGND DC 0 SIN( 0 -0.5 1k )
V6 IN_BAL_R_P AGND DC 0 SIN( 0 0.5 1k )
V7 IN_BAL_R_N AGND DC 0 SIN( 0 -0.5 1k )
RP2 WD_L_WIPER WET_SUM_L 10k
RP4 WD_R_WIPER WET_SUM_R 10k
RL4 DRY_L AGND 10k
V8 WET_SUM_L AGND DC 0 SIN( 0 0.3 500 )
V9 WET_SUM_R AGND DC 0 SIN( 0 0.3 500 )
RS1 R_RX MONO_C 10m
RL2 OUT_BAL_R_P OUT_BAL_R_N 600
RL3 WET_SEND_L AGND 10k
V1 +15VA GND DC 15
V3 AGND GND DC 0
V2 GND -15VA DC 15
R50 N_COLD_L OUT_BAL_L_N 49.9
R60 N_COLD_R OUT_BAL_R_N 49.9
C93 +15VA AGND 100n
C99 +15VA AGND 22u
C91 +15VA AGND 100n
C92 -15VA AGND 100n
C100 -15VA AGND 22u
C98 -15VA AGND 100n
XU4 N_HOT_R N_HOT_R R_BLEND -15VA AGND N_U4B_M N_COLD_R +15VA OPA1656X2
XU3 N_HOT_L N_HOT_L L_BLEND -15VA AGND N_U3B_M N_COLD_L +15VA OPA1656X2
R59 N_HOT_R OUT_BAL_R_P 49.9
R53 R_BLEND N_U4B_M 10k
R54 N_COLD_R N_U4B_M 10k
R43 L_BLEND N_U3B_M 10k
R44 N_COLD_L N_U3B_M 10k
R49 N_HOT_L OUT_BAL_L_P 49.9
C95 +15VA AGND 100n
C96 -15VA AGND 100n
C97 +15VA AGND 100n
C94 -15VA AGND 100n
.end
